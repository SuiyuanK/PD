* SPICE NETLIST
***************************************
.SUBCKT n11ll_ckt DRN GATE SRC BULK
.ENDS
***************************************
.SUBCKT n11ll_dnw_ckt DRN GATE SRC BULK
.ENDS
***************************************
.SUBCKT p11ll_ckt DRN GATE SRC BULK
.ENDS
***************************************
.SUBCKT nt11ll_ckt DRN GATE SRC BULK
.ENDS
***************************************
.SUBCKT nhvt11ll_ckt DRN GATE SRC BULK
.ENDS
***************************************
.SUBCKT nhvt11ll_dnw_ckt DRN GATE SRC BULK
.ENDS
***************************************
.SUBCKT phvt11ll_ckt DRN GATE SRC BULK
.ENDS
***************************************
.SUBCKT nlvt11ll_ckt DRN GATE SRC BULK
.ENDS
***************************************
.SUBCKT nulvt11ll_ckt DRN GATE SRC BULK
.ENDS
***************************************
.SUBCKT nulvt11ll_dnw_ckt DRN GATE SRC BULK
.ENDS
***************************************
.SUBCKT nlvt11ll_dnw_ckt DRN GATE SRC BULK
.ENDS
***************************************
.SUBCKT plvt11ll_ckt DRN GATE SRC BULK
.ENDS
***************************************
.SUBCKT pulvt11ll_ckt DRN GATE SRC BULK
.ENDS
***************************************
.SUBCKT n25ll_ckt DRN GATE SRC BULK
.ENDS
***************************************
.SUBCKT n25ll_dnw_ckt DRN GATE SRC BULK
.ENDS
***************************************
.SUBCKT p25ll_ckt DRN GATE SRC BULK
.ENDS
***************************************
.SUBCKT nt25ll_ckt DRN GATE SRC BULK
.ENDS
***************************************
.SUBCKT nod33ll_ckt DRN GATE SRC BULK
.ENDS
***************************************
.SUBCKT nod33ll_dnw_ckt DRN GATE SRC BULK
.ENDS
***************************************
.SUBCKT pod33ll_ckt DRN GATE SRC BULK
.ENDS
***************************************
.SUBCKT nud18ll_ckt DRN GATE SRC BULK
.ENDS
***************************************
.SUBCKT nud18ll_dnw_ckt DRN GATE SRC BULK
.ENDS
***************************************
.SUBCKT pud18ll_ckt DRN GATE SRC BULK
.ENDS
***************************************
.SUBCKT ntod33ll_ckt DRN GATE SRC BULK
.ENDS
***************************************
.SUBCKT ntud18ll_ckt DRN GATE SRC BULK
.ENDS
***************************************
.SUBCKT dplnfetpd_ckt DRN GATE SRC BULK
.ENDS
***************************************
.SUBCKT dplnfetwl_ckt DRN GATE SRC BULK
.ENDS
***************************************
.SUBCKT dplpfetpu_ckt DRN GATE SRC BULK
.ENDS
***************************************
.SUBCKT rflnfetpd_ckt DRN GATE SRC BULK
.ENDS
***************************************
.SUBCKT rflnfetwla_ckt DRN GATE SRC BULK
.ENDS
***************************************
.SUBCKT rflnfetwlb_ckt DRN GATE SRC BULK
.ENDS
***************************************
.SUBCKT rflpfetpu_ckt DRN GATE SRC BULK
.ENDS
***************************************
.SUBCKT dpcnfetpd_ckt DRN GATE SRC BULK
.ENDS
***************************************
.SUBCKT dpcnfetwla_ckt DRN GATE SRC BULK
.ENDS
***************************************
.SUBCKT dpcnfetwlb_ckt DRN GATE SRC BULK
.ENDS
***************************************
.SUBCKT dpcpfetpu_ckt DRN GATE SRC BULK
.ENDS
***************************************
.SUBCKT dslnfetpd_ckt DRN GATE SRC BULK
.ENDS
***************************************
.SUBCKT dslnfetwl_ckt DRN GATE SRC BULK
.ENDS
***************************************
.SUBCKT dslpfetpu_ckt DRN GATE SRC BULK
.ENDS
***************************************
.SUBCKT lshnfetpd_ckt DRN GATE SRC BULK
.ENDS
***************************************
.SUBCKT lshnfetwl_ckt DRN GATE SRC BULK
.ENDS
***************************************
.SUBCKT lshpfetpu_ckt DRN GATE SRC BULK
.ENDS
***************************************
.SUBCKT pvar11ll_ckt PLUS MINUS
.ENDS
***************************************
.SUBCKT dnwpvar11ll_ckt PLUS MINUS
.ENDS
***************************************
.SUBCKT nvar11ll_ckt PLUS MINUS
.ENDS
***************************************
.SUBCKT dnwnvar11ll_ckt PLUS MINUS
.ENDS
***************************************
.SUBCKT pvar25ll_ckt PLUS MINUS
.ENDS
***************************************
.SUBCKT dnwpvar25ll_ckt PLUS MINUS
.ENDS
***************************************
.SUBCKT nvar25ll_ckt PLUS MINUS
.ENDS
***************************************
.SUBCKT dnwnvar25ll_ckt PLUS MINUS
.ENDS
***************************************
.SUBCKT pnp11a100ll_ckt COLL BASE EMIT
.ENDS
***************************************
.SUBCKT pnp11a25ll_ckt COLL BASE EMIT
.ENDS
***************************************
.SUBCKT pnp11a4ll_ckt COLL BASE EMIT
.ENDS
***************************************
.SUBCKT npn11a4ll_ckt COLL BASE EMIT BULK
.ENDS
***************************************
.SUBCKT npn11a25ll_ckt COLL BASE EMIT BULK
.ENDS
***************************************
.SUBCKT npn11a100ll_ckt COLL BASE EMIT BULK
.ENDS
***************************************
.SUBCKT pnp25a100ll_ckt COLL BASE EMIT
.ENDS
***************************************
.SUBCKT pnp25a25ll_ckt COLL BASE EMIT
.ENDS
***************************************
.SUBCKT pnp25a4ll_ckt COLL BASE EMIT
.ENDS
***************************************
.SUBCKT npn25a4ll_ckt COLL BASE EMIT BULK
.ENDS
***************************************
.SUBCKT npn25a25ll_ckt COLL BASE EMIT BULK
.ENDS
***************************************
.SUBCKT npn25a100ll_ckt COLL BASE EMIT BULK
.ENDS
***************************************
.SUBCKT pnp11a100ll_sba_ckt COLL BASE EMIT
.ENDS
***************************************
.SUBCKT pnp11a25ll_sba_ckt COLL BASE EMIT
.ENDS
***************************************
.SUBCKT pnp11a4ll_sba_ckt COLL BASE EMIT
.ENDS
***************************************
.SUBCKT npn11a4ll_sba_ckt COLL BASE EMIT BULK
.ENDS
***************************************
.SUBCKT npn11a25ll_sba_ckt COLL BASE EMIT BULK
.ENDS
***************************************
.SUBCKT npn11a100ll_sba_ckt COLL BASE EMIT BULK
.ENDS
***************************************
.SUBCKT pnp25a100ll_sba_ckt COLL BASE EMIT
.ENDS
***************************************
.SUBCKT pnp25a25ll_sba_ckt COLL BASE EMIT
.ENDS
***************************************
.SUBCKT pnp25a4ll_sba_ckt COLL BASE EMIT
.ENDS
***************************************
.SUBCKT npn25a4ll_sba_ckt COLL BASE EMIT BULK
.ENDS
***************************************
.SUBCKT npn25a25ll_sba_ckt COLL BASE EMIT BULK
.ENDS
***************************************
.SUBCKT npn25a100ll_sba_ckt COLL BASE EMIT BULK
.ENDS
***************************************
.SUBCKT rndif_3t_ckt PLUS MINUS B
.ENDS
***************************************
.SUBCKT rpdif_3t_ckt PLUS MINUS B
.ENDS
***************************************
.SUBCKT rnwsti_3t_ckt PLUS MINUS B
.ENDS
***************************************
.SUBCKT rnwaa_3t_ckt PLUS MINUS B
.ENDS
***************************************
.SUBCKT rndifsab_3t_ckt PLUS MINUS B
.ENDS
***************************************
.SUBCKT rpdifsab_3t_ckt PLUS MINUS B
.ENDS
***************************************
.SUBCKT rnpo_3t_ckt PLUS MINUS B
.ENDS
***************************************
.SUBCKT rppo_3t_ckt PLUS MINUS B
.ENDS
***************************************
.SUBCKT rnposab_3t_ckt PLUS MINUS B
.ENDS
***************************************
.SUBCKT rpposab_3t_ckt PLUS MINUS B
.ENDS
***************************************
.SUBCKT rhrpo_3t_ckt PLUS MINUS B
.ENDS
***************************************
.SUBCKT rndif_2t_ckt PLUS MINUS
.ENDS
***************************************
.SUBCKT rpdif_2t_ckt PLUS MINUS
.ENDS
***************************************
.SUBCKT rnwsti_2t_ckt PLUS MINUS
.ENDS
***************************************
.SUBCKT rnwaa_2t_ckt PLUS MINUS
.ENDS
***************************************
.SUBCKT rndifsab_2t_ckt PLUS MINUS
.ENDS
***************************************
.SUBCKT rpdifsab_2t_ckt PLUS MINUS
.ENDS
***************************************
.SUBCKT rnpo_2t_ckt PLUS MINUS
.ENDS
***************************************
.SUBCKT rppo_2t_ckt PLUS MINUS
.ENDS
***************************************
.SUBCKT rnposab_2t_ckt PLUS MINUS
.ENDS
***************************************
.SUBCKT rpposab_2t_ckt PLUS MINUS
.ENDS
***************************************
.SUBCKT rhrpo_2t_ckt PLUS MINUS
.ENDS
***************************************
.SUBCKT rm1_2t_ckt PLUS MINUS
.ENDS
***************************************
.SUBCKT rm1_3t_ckt PLUS MINUS B
.ENDS
***************************************
.SUBCKT rm2_2t_ckt PLUS MINUS
.ENDS
***************************************
.SUBCKT rm2_3t_ckt PLUS MINUS B
.ENDS
***************************************
.SUBCKT rm3_2t_ckt PLUS MINUS
.ENDS
***************************************
.SUBCKT rm3_3t_ckt PLUS MINUS B
.ENDS
***************************************
.SUBCKT rm4_2t_ckt PLUS MINUS
.ENDS
***************************************
.SUBCKT rm4_3t_ckt PLUS MINUS B
.ENDS
***************************************
.SUBCKT ralpa_3t_ckt PLUS MINUS B
.ENDS
***************************************
.SUBCKT ralpa_2t_ckt PLUS MINUS
.ENDS
***************************************
.SUBCKT ralpa_2p8_3t_ckt PLUS MINUS B
.ENDS
***************************************
.SUBCKT ralpa_2p8_2t_ckt PLUS MINUS
.ENDS
***************************************
.SUBCKT rm5_2t_ckt PLUS MINUS
.ENDS
***************************************
.SUBCKT rm5_3t_ckt PLUS MINUS B
.ENDS
***************************************
.SUBCKT rm6_2t_ckt PLUS MINUS
.ENDS
***************************************
.SUBCKT rm6_3t_ckt PLUS MINUS B
.ENDS
***************************************
.SUBCKT rm7_2t_ckt PLUS MINUS
.ENDS
***************************************
.SUBCKT rm7_3t_ckt PLUS MINUS B
.ENDS
***************************************
.SUBCKT rm8_2t_ckt PLUS MINUS
.ENDS
***************************************
.SUBCKT rm8_3t_ckt PLUS MINUS B
.ENDS
***************************************
.SUBCKT rtm1_2t_ckt PLUS MINUS
.ENDS
***************************************
.SUBCKT rtm1_3t_ckt PLUS MINUS B
.ENDS
***************************************
.SUBCKT rtm2_2t_ckt PLUS MINUS
.ENDS
***************************************
.SUBCKT rtm2_3t_ckt PLUS MINUS B
.ENDS
***************************************
.SUBCKT rutm_2t_ckt PLUS MINUS
.ENDS
***************************************
.SUBCKT rutm_3t_ckt PLUS MINUS B
.ENDS
***************************************
.SUBCKT mom_3t_ckt PLUS MINUS B
.ENDS
***************************************
.SUBCKT mom_2t_ckt PLUS MINUS
.ENDS
***************************************
.SUBCKT nld50ll_ckt D G S B
.ENDS
***************************************
.SUBCKT pld50ll_ckt D G S B
.ENDS
***************************************
.SUBCKT nld50llod_ckt D G S B
.ENDS
***************************************
.SUBCKT pld50llod_ckt D G S B
.ENDS
***************************************
.SUBCKT EFUSE_res PLUS MINUS
.ENDS
***************************************
.SUBCKT mom_4t_ckt P1 M1 P2 M2
.ENDS
***************************************
.SUBCKT mom_5t_ckt P1 M1 P2 M2 B
.ENDS
***************************************
.SUBCKT mom33_3t_ckt PLUS MINUS B
.ENDS
***************************************
.SUBCKT mom33_2t_ckt PLUS MINUS
.ENDS
***************************************
.SUBCKT mom33_4t_ckt P1 M1 P2 M2
.ENDS
***************************************
.SUBCKT mom33_5t_ckt P1 M1 P2 M2 B
.ENDS
***************************************
.SUBCKT mom50_3t_ckt PLUS MINUS B
.ENDS
***************************************
.SUBCKT mom50_2t_ckt PLUS MINUS
.ENDS
***************************************
.SUBCKT mom50_4t_ckt P1 M1 P2 M2
.ENDS
***************************************
.SUBCKT mom50_5t_ckt P1 M1 P2 M2 B
.ENDS
***************************************
.SUBCKT navt_dnw_ckt DRN GATE SRC BULK
.ENDS
***************************************
.SUBCKT navt_ckt DRN GATE SRC BULK
.ENDS
***************************************
.SUBCKT pavt_ckt DRN GATE SRC BULK
.ENDS
***************************************
.SUBCKT nelvt_dnw_ckt DRN GATE SRC BULK
.ENDS
***************************************
.SUBCKT nelvt_ckt DRN GATE SRC BULK
.ENDS
***************************************
.SUBCKT pelvt_ckt DRN GATE SRC BULK
.ENDS
***************************************
.SUBCKT ulln_dnw_ckt DRN GATE SRC BULK
.ENDS
***************************************
.SUBCKT ulln_ckt DRN GATE SRC BULK
.ENDS
***************************************
.SUBCKT ullp_ckt DRN GATE SRC BULK
.ENDS
***************************************
.SUBCKT stnpdull_ckt DRN GATE SRC BULK
.ENDS
***************************************
.SUBCKT stnpgull_ckt DRN GATE SRC BULK
.ENDS
***************************************
.SUBCKT stplull_ckt DRN GATE SRC BULK
.ENDS
***************************************
